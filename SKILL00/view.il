; Author:	wing, v1.0
axlCmdRegister( "BA" 'all_view)
axlCmdRegister( "BN" 'no_view)
axlCmdRegister( "BT" 'ART_TOP)
axlCmdRegister( "BB" 'ART_BOTTOM)
axlCmdRegister( "BV" 'ART_TB)
;不能用
axlCmdRegister( "BE" 'openRefdes_T)
axlCmdRegister( "BF" 'openRefdes_B)
axlCmdRegister( "BG" 'refdes_Close)
axlCmdRegister( "BH" 'SILKSCREE)
axlCmdRegister( "BJ" 'SILKSCR)
axlCmdRegister( "BQ" 'SILKSCRE)
axlCmdRegister( "BW" 'SILKSCREEN)
axlCmdRegister( "DF" 'Delete_Fixed)

axlCmdRegister( "B1" 'TOPVIEW)
axlCmdRegister( "B2" 'BOTVIEW)

axlCmdRegister( "upsp" 'SHAPE_UPDATE)
	;刷新铜皮

axlCmdRegister( "1" 'LAYER_TOP)
axlCmdRegister( "2" 'LAYER_2)
axlCmdRegister( "3" 'LAYER_3)
axlCmdRegister( "4" 'LAYER_BOTTOM)

defun( LAYER_TOP ()
	axlShell("replay D:/OneDrive/C_Library/SKILL/layer_top.scr")
	)
defun( LAYER_2 ()
	axlShell("replay D:/OneDrive/C_Library/SKILL/layer_2.scr")
	)
defun( LAYER_3 ()
	axlShell("replay D:/OneDrive/C_Library/SKILL/layer_3.scr")
	)
defun( LAYER_BOTTOM ()
	axlShell("replay D:/OneDrive/C_Library/SKILL/layer_bottom.scr")
	)

;silkscreen
defun( TOPVIEW ()
       	 axlVisibleDesign(nil)
	axlVisibleLayer( "PIN/SOLDERMASK_TOP" t )
	axlVisibleLayer( "VIA CLASS/SOLDERMASK_TOP" t )
	axlVisibleLayer( "PACKAGE GEOMETRY/SILKSCREEN_TOP" t )
	axlVisibleLayer( "Drawing Format/Drawing_Origin" t )
       	axlVisibleLayer( "BOARD GEOMETRY/CUTOUT" t )
       	axlVisibleLayer( "BOARD GEOMETRY/Design_OUTLINE" t )
	axlVisibleLayer( "BOARD GEOMETRY/SOLDERMASK_TOP" t )
       	axlVisibleLayer( "BOARD GEOMETRY/SILKSCREEN_TOP" t )
       	axlVisibleLayer( "PACKAGE GEOMETRY/SOLDERMASK_TOP" t )
       	axlVisibleLayer( "PACKAGE GEOMETRY/SILKSCREEN_TOP" t )
        	axlVisibleLayer( "PACKAGE GEOMETRY/PLACE_BOUND_TOP" t )
        	axlVisibleLayer( "REF DES/SILKSCREEN_TOP" t )
       	axlVisibleLayer( "ROUTE KEEPIN/ALL" t )
       	axlVisibleLayer( "DRC ERROR CLASS/PACKAGE_TOP" t)
	axlVisibleLayer(  "ROUTE KEEPOUT/ALL" t )
	axlVisibleLayer( "Package KEEPIN/ALL" t )
	axlVisibleLayer( "Package KEEPOUT/ALL" t )
	axlVisibleLayer( "VIA CLASS/TOP" t )
	axlVisibleLayer( "ETCH/TOP" t )
	axlUIWRedraw(nil)
	)

defun( BOTVIEW ()
       	axlVisibleDesign(nil)
	axlVisibleLayer( "PIN/SOLDERMASK_BOTTOM" t )
	axlVisibleLayer( "VIA CLASS/SOLDERMASK_BOTTOM" t )
	axlVisibleLayer( "PACKAGE GEOMETRY/SILKSCREEN_BOTTOM" t )
	axlVisibleLayer( "Drawing Format/Drawing_Origin" t )
       	axlVisibleLayer( "BOARD GEOMETRY/CUTOUT" t )
       	axlVisibleLayer( "BOARD GEOMETRY/Design_OUTLINE" t )
	axlVisibleLayer( "BOARD GEOMETRY/SOLDERMASK_BOTTOM" t )
       	axlVisibleLayer( "BOARD GEOMETRY/SILKSCREEN_BOTTOM" t )
       	axlVisibleLayer( "PACKAGE GEOMETRY/SOLDERMASK_BOTTOM" t )
       	axlVisibleLayer( "PACKAGE GEOMETRY/SILKSCREEN_BOTTOM" t )
        	axlVisibleLayer( "PACKAGE GEOMETRY/PLACE_BOUND_BOTTOM" t )
        	axlVisibleLayer( "REF DES/SILKSCREEN_BOTTOM" t )
       	axlVisibleLayer( "ROUTE KEEPIN/ALL" t )
       	axlVisibleLayer( "DRC ERROR CLASS/PACKAGE_BOTTOM" t)
	axlVisibleLayer(  "ROUTE KEEPOUT/ALL" t )
	axlVisibleLayer( "Package KEEPIN/ALL" t )
	axlVisibleLayer( "Package KEEPOUT/ALL" t )
	axlVisibleLayer( "VIA CLASS/BOTTOM" t )
	axlVisibleLayer( "ETCH/BOTTOM" t )
	axlUIWRedraw(nil)
	)

defun( SHAPE_UPDATE ()
	axlShapeDynamicUpdate( nil t )
	;刷新铜皮
	)

defun( all_view ()
     axlVisibleDesign(t)
;设置design的状态是显示还是不显示
     axlUIWRedraw(nil)
	)

defun( no_view ()
     axlVisibleDesign(nil)
     axlUIWRedraw(nil)
	)

;display top only.
defun( ART_TOP ()
       	axlVisibleDesign(nil)
	axlVisibleLayer( "ETCH/TOP" t )
	axlVisibleLayer( "PIN/TOP" t )
	axlVisibleLayer( "VIA CLASS/TOP" t )
	axlVisibleLayer( "DRC ERROR CLASS/TOP" t )
	axlVisibleLayer( "PACKAGE GEOMETRY/SILKSCREEN_TOP" t )
	axlVisibleLayer( "Drawing Format/Drawing_Origin" t )
	;axlVisibleLayer( "PACKAGE GEOMETRY/ASSEMBLY_TOP" t )
	;axlVisibleLayer( "REF DES/SILKSCREEN_TOP" t )
	axlVisibleLayer( "ETCH/BOTTOM" nil )
	axlVisibleLayer( "PIN/BOTTOM" nil)
	axlVisibleLayer( "VIA CLASS/BOTTOM" nil )
	axlVisibleLayer( "DRC ERROR CLASS/BOTTOM" nil)
	axlVisibleLayer( "PACKAGE GEOMETRY/SILKSCREEN_BOTTOM" nil )
    	axlVisibleLayer( "BOARD GEOMETRY/OUTLINE" t )
    	axlVisibleLayer( "BOARD GEOMETRY/PAGELINE" t )
	axlVisibleLayer( "BOARD GEOMETRY/CONSTRAINT_AREA" t )
       	 ;axlVisibleLayer( "PACKAGE GEOMETRY/PLACE_BOUND_TOP" t )
       	axlVisibleLayer( "ROUTE KEEPIN/ALL" t )
       	axlVisibleLayer( "ANTI ETCH/ALL" t )
        	axlVisibleLayer( "BOARD GEOMETRY/SILKSCREEN_TOP" t )
	axlUIWRedraw(nil)
	)

;display bottom only.
defun( ART_BOTTOM ()
        	axlVisibleDesign(nil)
	axlVisibleLayer( "ETCH/BOTTOM" t )
	axlVisibleLayer( "PIN/BOTTOM" t )
	axlVisibleLayer( "VIA CLASS/BOTTOM" t )
	axlVisibleLayer( "DRC ERROR CLASS/BOTTOM" t )
        	axlVisibleLayer( "BOARD GEOMETRY/OUTLINE" t )
        	axlVisibleLayer( "BOARD GEOMETRY/PAGELINE" t )
	axlVisibleLayer( "PACKAGE GEOMETRY/SILKSCREEN_BOTTOM" t )
	axlVisibleLayer( "Drawing Format/Drawing_Origin" t )
	;axlVisibleLayer( "PACKAGE GEOMETRY/ASSEMBLY_BOTTOM" t )
	;axlVisibleLayer( "REF DES/SILKSCREEN_BOTTOM" t )
	axlVisibleLayer( "ETCH/TOP" nil )
	axlVisibleLayer( "PIN/TOP" nil )
	axlVisibleLayer( "VIA CLASS/TOP" nil )
	axlVisibleLayer( "DRC ERROR CLASS/TOP" nil )
	axlVisibleLayer( "PACKAGE GEOMETRY/SILKSCREEN_TOP" nil )
	axlVisibleLayer( "BOARD GEOMETRY/CONSTRAINT_AREA" t )
        	axlVisibleLayer( "ROUTE KEEPIN/ALL" t )
        	;axlVisibleLayer( "PACKAGE GEOMETRY/PLACE_BOUND_BOTTOM" t )
       	 axlVisibleLayer( "ANTI ETCH/ALL" t )
        	axlVisibleLayer( "BOARD GEOMETRY/SILKSCREEN_BOTTOM" t )
	axlUIWRedraw(nil)
	)

;display top and bottom.
defun( ART_TB ()
        	axlVisibleDesign(nil)
	axlVisibleLayer( "ETCH/TOP" t )
	axlVisibleLayer( "PIN/TOP" t )
	axlVisibleLayer( "VIA CLASS/TOP" t )
	axlVisibleLayer( "DRC ERROR CLASS/TOP" t )
	axlVisibleLayer( "ETCH/BOTTOM" t )
	axlVisibleLayer( "PIN/BOTTOM" t )
	axlVisibleLayer( "VIA CLASS/BOTTOM" t )
	axlVisibleLayer( "DRC ERROR CLASS/BOTTOM" t )
        	axlVisibleLayer( "BOARD GEOMETRY/OUTLINE" t )
	axlVisibleLayer( "PACKAGE GEOMETRY/SILKSCREEN_TOP" t )
	axlVisibleLayer( "PACKAGE GEOMETRY/SILKSCREEN_BOTTOM" t )
	axlVisibleLayer( "Drawing Format/Drawing_Origin" t )
	axlVisibleLayer( "BOARD GEOMETRY/CONSTRAINT_AREA" t )
       	axlVisibleLayer( "ROUTE KEEPIN/ALL" t )
        	axlVisibleLayer( "BOARD GEOMETRY/SILKSCREEN_TOP" t )
	axlVisibleLayer( "BOARD GEOMETRY/SILKSCREEN_BOTTOM" t )
       	axlVisibleLayer( "ANTI ETCH/ALL" t )
	axlUIWRedraw(nil)
	)

;Refdes
defun( openRefdes_B  ()
        	axlVisibleDesign(nil)
	axlVisibleLayer( "PIN/SOLDERMASK_BOTTOM" t )
	axlVisibleLayer( "VIA CLASS/SOLDERMASK_BOTTOM" t )
	axlVisibleLayer( "PACKAGE GEOMETRY/SILKSCREEN_BOTTOM" t )
	axlVisibleLayer( "Drawing Format/Drawing_Origin" t )
        	axlVisibleLayer( "BOARD GEOMETRY/OUTLINE" t )
	axlVisibleLayer( "BOARD GEOMETRY/SOLDERMASK_BOTTOM" t )
        	axlVisibleLayer( "BOARD GEOMETRY/SILKSCREEN_BOTTOM" t )
        	axlVisibleLayer( "PACKAGE GEOMETRY/SOLDERMASK_BOTTOM" t )
        	axlVisibleLayer( "PACKAGE GEOMETRY/SILKSCREEN_BOTTOM" t )
       	 axlVisibleLayer( "REF DES/SILKSCREEN_BOTTOM" t )
        	axlVisibleLayer( "ROUTE KEEPIN/ALL" t )
	axlUIWRedraw(nil)
   )

defun( openRefdes_T ()
	axlVisibleDesign(nil)
	axlVisibleLayer( "PIN/SOLDERMASK_TOP" t )
	axlVisibleLayer( "VIA CLASS/SOLDERMASK_TOP" t )
	axlVisibleLayer( "PACKAGE GEOMETRY/SILKSCREEN_TOP" t )
	axlVisibleLayer( "Drawing Format/Drawing_Origin" t )
        	axlVisibleLayer( "BOARD GEOMETRY/OUTLINE" t )
	axlVisibleLayer( "BOARD GEOMETRY/SOLDERMASK_TOP" t )
        	axlVisibleLayer( "BOARD GEOMETRY/SILKSCREEN_TOP" t )
        	axlVisibleLayer( "PACKAGE GEOMETRY/SOLDERMASK_TOP" t )
        	axlVisibleLayer( "PACKAGE GEOMETRY/SILKSCREEN_TOP" t )
        	axlVisibleLayer( "REF DES/SILKSCREEN_TOP" t )
        	axlVisibleLayer( "ROUTE KEEPIN/ALL" t )
	axlUIWRedraw(nil)
	)

defun( refdes_Close ()
	axlVisibleLayer( "REF DES/SILKSCREEN_TOP" nil )
	axlVisibleLayer( "REF DES/SILKSCREEN_BOTTOM" nil )
	axlUIWRedraw(nil)
	)

;silkscreen
defun( SILKSCREE ()
       	 axlVisibleDesign(nil)
	axlVisibleLayer( "PIN/SOLDERMASK_TOP" t )
	axlVisibleLayer( "VIA CLASS/SOLDERMASK_TOP" t )
	axlVisibleLayer( "PACKAGE GEOMETRY/SILKSCREEN_TOP" t )
	axlVisibleLayer( "Drawing Format/Drawing_Origin" t )
       	 axlVisibleLayer( "BOARD GEOMETRY/OUTLINE" t )
	axlVisibleLayer( "BOARD GEOMETRY/SOLDERMASK_TOP" t )
       	 axlVisibleLayer( "BOARD GEOMETRY/SILKSCREEN_TOP" t )
       	 axlVisibleLayer( "PACKAGE GEOMETRY/SOLDERMASK_TOP" t )
       	 axlVisibleLayer( "PACKAGE GEOMETRY/SILKSCREEN_TOP" t )
        	axlVisibleLayer( "PACKAGE GEOMETRY/PLACE_BOUND_TOP" t )
       	 axlVisibleLayer( "ROUTE KEEPIN/ALL" t )
       	 axlVisibleLayer( "DRC ERROR CLASS/PACKAGE_TOP" t)
	axlUIWRedraw(nil)
	)

defun( SILKSCR ()
	axlVisibleDesign(nil)
	axlVisibleLayer( "PIN/SOLDERMASK_BOTTOM" t )
	axlVisibleLayer( "VIA CLASS/SOLDERMASK_BOTTOM" t )
	axlVisibleLayer( "PACKAGE GEOMETRY/SILKSCREEN_BOTTOM" t )
	axlVisibleLayer( "Drawing Format/Drawing_Origin" t )
     	axlVisibleLayer( "BOARD GEOMETRY/OUTLINE" t )
	axlVisibleLayer( "BOARD GEOMETRY/SOLDERMASK_BOTTOM" t )
     	axlVisibleLayer( "BOARD GEOMETRY/SILKSCREEN_BOTTOM" t )
        	axlVisibleLayer( "PACKAGE GEOMETRY/SOLDERMASK_BOTTOM" t )
        	axlVisibleLayer( "PACKAGE GEOMETRY/SILKSCREEN_BOTTOM" t )
        	axlVisibleLayer( "PACKAGE GEOMETRY/PLACE_BOUND_BOTTOM" t )
        	axlVisibleLayer( "ROUTE KEEPIN/ALL" t )
        	axlVisibleLayer( "DRC ERROR CLASS/PACKAGE_BOTTOM" t)
	axlUIWRedraw(nil)
	)

defun( SILKSCRE ()
	axlVisibleLayer( "PACKAGE GEOMETRY/SILKSCREEN_TOP" t )
	axlVisibleLayer( "PACKAGE GEOMETRY/SILKSCREEN_BOTTOM" t )
	axlUIWRedraw(nil)
	)

defun( SILKSCREEN ()
	axlVisibleLayer( "PACKAGE GEOMETRY/SILKSCREEN_TOP" nil )
	axlVisibleLayer( "PACKAGE GEOMETRY/SILKSCREEN_BOTTOM" nil )
	axlUIWRedraw(nil)
	)

defun( Delete_Fixed ()
	axlDBDeleteProp(axlDBGetDesign()->symbols "FIXED_PRIVATE")
	)
